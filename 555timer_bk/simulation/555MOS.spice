** sch_path: /home/ishi-kai/555/555timer_bk/555MOS.sch
.subckt 555MOS vdd th out vctrl trig vss rst dischg
*.PININFO vctrl:I out:O trig:I th:I rst:I dischg:O vdd:B vss:B
MM2 net2 vctrl net5 vss NMOS w=20u l=2u m=1
MM1 net1 th net5 vss NMOS w=20u l=2u m=1
MM3 net1 net1 vdd vdd PMOS w=20u l=2u m=1
MM4 net4 net1 vdd vdd PMOS w=20u l=2u m=1
MM5 net3 net2 vdd vdd PMOS w=20u l=2u m=1
MM6 net2 net2 vdd vdd PMOS w=20u l=2u m=1
MM7 net7 net11 net6 vdd PMOS w=80u l=2u m=1
XR2 vdd net6 vdd F_RR w=6e-06 l=13.2e-06 m=1
MM8 net8 trig net7 vdd PMOS w=40u l=2u m=1
MM9 net9 net10 net7 vdd PMOS w=40u l=2u m=1
MM10 net8 net9 vss vss NMOS w=20u l=2u m=1
MM11 net9 net9 vss vss NMOS w=20u l=2u m=1
XR3 vdd vctrl vdd F_RR w=4e-06 l=42e-06 m=1
XR4 vctrl net10 vdd F_RR w=4e-06 l=42e-06 m=1
XR5 net10 vss vdd F_RR w=4e-06 l=42e-06 m=1
MM12 net3 net3 vss vss NMOS w=20u l=2u m=1
MM13 net4 net3 vss vss NMOS w=20u l=2u m=1
MM14 net11 net11 vdd vdd PMOS w=40u l=2u m=1
MM15 net15 net11 vdd vdd PMOS w=40u l=2u m=1
MM16 net12 net4 net13 vss NMOS w=20u l=2u m=1
MM17 net12 net12 net14 vss NMOS w=20u l=2u m=1
XR6 net11 net12 vdd F_RR w=4e-06 l=24.6e-06 m=1
MM18 net13 net8 vss vss NMOS w=20u l=2u m=1
MM19 net14 net13 vss vss NMOS w=20u l=2u m=1
MM20 net15 net14 vss vss NMOS w=20u l=2u m=1
MM21 net16 net15 net18 vss NMOS w=20u l=2u m=1
XR7 net15 net13 vdd F_RR w=4e-06 l=23.5e-06 m=1
XR8 vdd net16 vdd F_RR w=4e-06 l=24.6e-06 m=1
MM24 vdd net17 out vss NMOS w=40u l=2u m=1
MM25 out net18 vss vss NMOS w=40u l=2u m=1
MM22 vdd net16 net17 vss NMOS w=20u l=2u m=1
MM23 vss net16 out vdd PMOS w=40u l=2u m=1
XR9 net17 out vdd F_RR w=4e-06 l=24.6e-06 m=1
XR10 net18 vss vdd F_RR w=4e-06 l=24.6e-06 m=1
MM26 net18 rst net12 vdd PMOS w=40u l=2u m=1
MM27 dischg net18 vss vss NMOS w=40u l=2u m=1
MM28 net5 net19 vss vss NMOS w=40u l=2u m=1
XR1 vdd net19 vdd F_RR w=4e-06 l=42e-06 m=1
MM29 net19 net19 vss vss NMOS w=40u l=2u m=1
.ends
